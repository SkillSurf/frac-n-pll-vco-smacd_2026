** sch_path: /foss/designs/frac-n-pll-vco-unic_cass/schematic/lc-vco/LC_VCO_tb.sch
**.subckt LC_VCO_tb
V1 VDD GND 1.2
Vup VCTRL GND PULSE(0.4 0.6 10n 90n 1n 1s 2s)
x1 VDD VCTRL GND OUT VBGR LC_VCO
VBGR VBGR GND 0.6
**** begin user architecture code

.include ../ihp_4nh_inductor.spice
.param temp = 27
.options method=gear, rshunt=1.0e12

.control

* Save required signals
save v(OUT) v(VCTRL)

* Long transient simulation
tran 10p 500n 100n

* Save raw waveform
write LC_VCO_tb.raw

* Plot transient waveform
let vout = v(OUT)
plot vout v(Vctrl)

* Plot steady-state waveform
plot vout xlimit 200n 205n

* FFT analysis
setplot tran1
linearize vout
set specwindow=blackman
fft vout

* Plot FFT spectrum
let vout_db = db(vout)
plot vout_db xlimit 2.35G 2.55G ylimit -150 0

* Find the maximum magnitude value between 2G and 3G
meas sp max_vout_db max vout_db FROM=2G TO=3G

* Save FFT data
wrdata fft_output.txt frequency vout_db

* Save waveform for external processing
wrdata vco_waveform.txt vout_db

.endc

.lib cornerMOSlv.lib mos_tt
.lib cornerMOShv.lib mos_tt
.lib cornerRES.lib res_typ
.lib cornerCAP.lib cap_typ

**** end user architecture code
**.ends

* expanding   symbol:  LC_VCO.sym # of pins=5
** sym_path: /foss/designs/frac-n-pll-vco-unic_cass/schematic/lc-vco/LC_VCO.sym
** sch_path: /foss/designs/frac-n-pll-vco-unic_cass/schematic/lc-vco/LC_VCO.sch
.subckt LC_VCO VDD VCTRL GND OUT VBGR
*.opin OUT
*.ipin VCTRL
*.ipin VBGR
*.iopin VDD
*.iopin GND
XM5 Vx Vgs GND GND sg13_lv_nmos w=70.29u l=0.5u ng=20
XM4 net1 net5 VDD VDD sg13_lv_pmos w=34.52u l=0.13u ng=10
XM3 net5 net1 VDD VDD sg13_lv_pmos w=34.52u l=0.13u ng=10
XM2 OUTp OUTn net4 GND sg13_lv_nmos w=25.11u l=0.13u ng=8
XM1 OUTn OUTp net4 GND sg13_lv_nmos w=25.11u l=0.13u ng=8
Vpmos_p net1 net3 0
.save i(vpmos_p)
Vnmos_p net3 OUTp 0
.save i(vnmos_p)
Vtail net4 Vx 0
.save i(vtail)
XM6 Vgs Vgs GND GND sg13_lv_nmos w=17.95u l=0.5u ng=6
Vpmos_n net5 net2 0
.save i(vpmos_n)
Vnmos_n net2 OUTn 0
.save i(vnmos_n)
x1 net2 net3 ihp_4nh_inductor
XC1 net2 net3 GND cap_rfcmim w=21.77e-6 l=21.77e-6 wfeed=10.0e-6
XC3 OUTp VCTRL OUTn GND sg13_hv_svaricap w=9.74u l=0.8u Nx=7
XC2 OUTp VCTRL OUTn GND sg13_hv_svaricap w=9.74u l=0.8u Nx=7
XM7 Vgs VBGR VDD VDD sg13_lv_pmos w=16.72u l=0.5u ng=6
XM8 OUT net3 VDD VDD sg13_lv_pmos w=25.10u l=0.13u ng=15
XM9 OUT net3 GND GND sg13_lv_nmos w=1.64u l=0.13u ng=1
XM10 net6 net2 VDD VDD sg13_lv_pmos w=25.10u l=0.13u ng=15
XM11 net6 net2 GND GND sg13_lv_nmos w=1.64u l=0.13u ng=1
.ends

.GLOBAL GND
.GLOBAL VDD
.GLOBAL VBGR
.GLOBAL VCTRL
.end
